;; Number notation
setup(?numberNotation 'engineering)

;; Simulator
simulator( 'spectre )
design(	 "/home/mdm.fernandes/IC6_workspace/simulation/COMMON_SOURCE/spectre/schematic/netlist/netlist")
resultsDir( "/home/mdm.fernandes/IC6_workspace/simulation/COMMON_SOURCE/spectre/schematic" )

;; Model Files
modelFile(
    '("/home/mdm.fernandes/IC6_workspace/nominal/spectre/nominalwrapper.scs" "")
)
definitionFile(
    "models.scs"
)

;; Set simulations
analysis('ac ?start "10k"  ?stop "1G"  )
analysis('dc ?saveOppoint t  )
envOption(
	'analysisOrder  list("dc" "ac")
)

temp( 27 )
