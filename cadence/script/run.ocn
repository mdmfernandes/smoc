;; Output file
out_path = getShellEnvVar("RESULT_FILE")
outf = outfile(out_path "w")

;; Run simulation
run()

;; Get results
POWER = -(VDC("/vdd") * IDC("/V1/PLUS"))
GAIN = ymax(dB20(VF("/net3")))
REG1 = pv("/M1" "region" ?result "dcOpInfo-info")
REG2 = pv("/M2" "region" ?result "dcOpInfo-info")
GBW = gainBwProd(VF("/net3"))
OS = (((1.2 - pv("/M1" "vdsat" ?result "dcOpInfo-info")) + pv("/M2" "vdsat" ?result "dcOpInfo-info")) - 0.1)

;; Save results to file
fprintf( outf "%s\t%e\n", "POWER", POWER)
fprintf( outf "%s\t%g\n", "GAIN", GAIN)
fprintf( outf "%s\t%d\n", "REG1", REG1)
fprintf( outf "%s\t%d\n", "REG2", REG2)
fprintf( outf "%s\t%g\n", "GBW", GBW)
fprintf( outf "%s\t%g", "OS", OS)

;; Close file
close(outf)
