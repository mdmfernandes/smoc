;====================== Open output file =======================================
out_path = getShellEnvVar("RESULT_FILE")
outf = outfile(out_path "w")

;====================== Run simulation =========================================
ocnxlRun( ?mode 'sweepsAndCorners ?nominalCornerEnabled t ?allCornersEnabled nil ?allSweepsEnabled nil)
; ?verboseMode nil

;====================== Print to file ==========================================
; Get the number of simulations from an environment variable
n_sim = getShellEnvVar("PAIM_N_SIM")
n_sim = atoi(n_sim)

for( i 1 n_sim
    sprintf(name "test:%d" i)

	POWER = calcVal("POWER" name)
    GAIN = calcVal("GAIN" name)
    REG1 = calcVal("REG1" name)
    REG2 = calcVal("REG2" name)
    GBW = calcVal("GBW" name ?defaultVal 24.2424)
    OS = 0.9

    fprintf( outf "%s\t%e\n", "POWER", POWER)
    fprintf( outf "%s\t%g\n", "GAIN", GAIN)
    fprintf( outf "%s\t%d\n", "REG1", REG1)
    fprintf( outf "%s\t%d\n", "REG2", REG2)
    fprintf( outf "%s\t%g\n", "GBW", GBW)
    fprintf( outf "%s\t%g\n", "OS", OS)
)

;====================== Close file =============================================
close(outf)
