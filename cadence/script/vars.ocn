desVar(	  "IB" 100u	)
desVar(	  "L" 240n	)
desVar(	  "VBIAS" 600m	)
desVar(	  "W1" 2u	)
desVar(	  "W2" 6u	)
