;======================= Run command ==========================
ocnxlRun( ?mode 'sweepsAndCorners ?nominalCornerEnabled t ?allCornersEnabled nil ?allSweepsEnabled nil ?verboseMode nil)

;====================== Open output file ======================
out_path = getShellEnvVar("SMOC_RESULT_FILE")
outf = outfile(out_path "w")

;====================== Print to file =========================
; Get the number of parallel simulations from an environment variable
n_sim = getShellEnvVar("SMOC_NUM_EVALS")
n_sim = atoi(n_sim)

for( i 1 n_sim
    sprintf(name "test:%d" i)

    ; Modify from here
	POWER = calcVal("POWER" name)
    GAIN = calcVal("GAIN" name)
    REG1 = calcVal("REG1" name)
    REG2 = calcVal("REG2" name)
    GBW = calcVal("GBW" name)
    OS = 0.9

    fprintf( outf "%s\t%e\n", "POWER", POWER)
    fprintf( outf "%s\t%g\n", "GAIN", GAIN)
    fprintf( outf "%s\t%d\n", "REG1", REG1)
    fprintf( outf "%s\t%d\n", "REG2", REG2)
    fprintf( outf "%s\t%g\n", "GBW", GBW)
    fprintf( outf "%s\t%g\n", "OS", OS)
    ; Modify up to here
)

;====================== Close output file =====================
close(outf)
