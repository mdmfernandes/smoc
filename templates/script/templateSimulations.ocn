simulator( 'spectre )
design(	 "/home/mdm.fernandes/IC6_workspace/simulation/COMMON_SOURCE/spectre/schematic/netlist/netlist")
modelFile(
    '("/home/mdm.fernandes/IC6_workspace/nominal/spectre/nominalwrapper.scs" "")
)
definitionFile(
    "models.scs"
)
analysis('ac ?start "10k"  ?stop "1G"  )
analysis('dc ?saveOppoint t  )
desVar(	  "IB" 100u	)
desVar(	  "L" 0.28	)
desVar(	  "VBIAS" 500m	)
desVar(	  "W1" 2	)
desVar(	  "W2" 6	)
envOption(
	'analysisOrder  list("dc" "ac")
)
temp( 27 )
ocnxlOutputExpr( "ymax(mag(v(\"/out\" ?result \"ac\")))" ?name "GAIN" ?plot t)
ocnxlOutputExpr( "pv(\"M2.m1\" \"region\" ?result \"dcOpInfo\")" ?name "REG2" ?plot t)
ocnxlOutputExpr( "pv(\"M1.m1\" \"region\" ?result \"dcOpInfo\")" ?name "REG1" ?plot t)
ocnxlOutputExpr( "gainBwProd(mag(v(\"/out\" ?result \"ac\"))) || 0.0" ?name "GBW" ?plot t)
ocnxlOutputExpr( "(- pv(\"V0\" \"pwr\" ?result \"dcOpInfo\"))" ?name "POWER" ?plot t)
