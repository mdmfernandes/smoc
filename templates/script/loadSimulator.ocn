setup(?numberNotation 'engineering)
ddCreateLib("OPTIMIZER_TEST" "/home/mdm.fernandes/Projects/optimizer/OPTIMIZER_TEST")

;====================== Set to XL mode =========================================
ocnSetXLMode()
ocnxlProjectDir( "/home/mdm.fernandes/IC6_workspace/simulation" )
ocnxlTargetCellView( "OPTIMIZER_TEST" "COMMON_SOURCE" "adexl" )
ocnxlResultsLocation( "" )
ocnxlSimResultsLocation( "" )
ocnxlMaxJobFail( 20 )

;====================== Tests setup ============================================

load(getShellEnvVar("SMOC_SET_SIM_FILE"))

;====================== Job setup ==============================================
ocnxlJobSetup( '(
	"blockemail" "1"
	"configuretimeout" "300"
	"distributionmethod" "Local"
	"lingertimeout" "300"
	"maxjobs" "4"
	"name" "ADE XL Default"
	"preemptivestart" "1"
	"reconfigureimmediately" "1"
	"runtimeout" "-1"
	"showerrorwhenretrying" "0"
	"showoutputlogerror" "0"
	"startmaxjobsimmed" "1"
	"starttimeout" "300"
	"usesameprocess" "1"
) )
