ocnxlSelectTest("test:1")
desVar(	  "IB" 400u	)
desVar(	  "L" 0.28	)
desVar(	  "VBIAS" 500m	)
desVar(	  "W1" 2	)
desVar(	  "W2" 6	)
ocnxlSelectTest("test:2")
desVar(	  "IB" 400u	)
desVar(	  "L" 0.28	)
desVar(	  "VBIAS" 500m	)
desVar(	  "W1" 2	)
desVar(	  "W2" 6	)
ocnxlSelectTest("test:3")
desVar(	  "IB" 400u	)
desVar(	  "L" 0.28	)
desVar(	  "VBIAS" 500m	)
desVar(	  "W1" 2	)
desVar(	  "W2" 6	)
ocnxlSelectTest("test:4")
desVar(	  "IB" 400u	)
desVar(	  "L" 0.28	)
desVar(	  "VBIAS" 500m	)
desVar(	  "W1" 2	)
desVar(	  "W2" 6	)
